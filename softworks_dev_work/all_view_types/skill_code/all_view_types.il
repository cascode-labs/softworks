/*****************************************************************
 *                                                               *
 *    Template SKILL view                                        *
 *                                                               *
 *  Functions should start with a capitalized 3 letter prefix    *
 *   such as "Tmp"                                               *
 *                                                               *
 *****************************************************************/
printf("Loading Tmp\n")

procedure(TmpDoSomething(a) let(()
	nil
))
