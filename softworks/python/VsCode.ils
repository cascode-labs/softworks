printf("  Loading VScode support...")
let((VsCode
     (Project VrtImport['IDS]->Project)
     (Path VrtImport['Path]))

VsCode =let(()

procedure(start()
  "Start a new VS Code Session"
  let((workspace_path cmd)
  workspace_path = setup_workspace()
	cmd = sprintf(nil "exec code %s; exit" workspace_path)
	printf("Starting VScode\n")
	printf("VScode: %s\n" cmd)
	VScodeProcess = ipcBeginProcess(cmd ""
		outputCallback
		errorCallback)
	printf("VScode process started: %A\n" VScodeProcess)
))

; Open a file in VScode
procedure(openFile(filePath)
		printf("VScode: Opening %s" filePath)
		start()  ; Open or select the Code workspace window first
		cmd = sprintf(nil "exec code %s; exit" filePath) ; update
		printf("VScode: %s\n" cmd)
		openPid = ipcBeginProcess(cmd ""
			outputCallback
			errorCallback)
)

; Callback for VScode stdout
procedure(outputCallback(o_childId t_data)
	if(t_data == sprintf(nil "VScode exited\n") then
		stop()
	else
		printf("VS Code: %s" t_data))
)

; Callback for VScode stderr
procedure(errorCallback(o_childId t_data)
	warn("VScode: %s" t_data))

; Called when VScode exits
procedure(exitCallback(o_childId x_exitStatus)
	printf("VS Code Exited")
	VScodeProcess = nil
)

procedure(setup_workspace()
  "Returns the project's VS Code workspace and creates the directory if it doesn't already exist."
  let((workspace_path)
  if(getShellEnvVar("SOFTWORKS_WORKSPACE_PATH") then
		workspace_path = getShellEnvVar("SOFTWORKS_WORKSPACE_PATH")
	else
    workspace_path = Path->Cat(
      Project->Path()
      "work_libs"
      getLogin()
      strcat(Project->Name() "_code"))
	)
  unless(isReadable(workspace_path)
    createDirHier(workspace_path))
  workspace_path
))

procedure(StartLmgrCB(_MenuName _Lib _Cell _View _a _b)
	start())

procedure(StopLmgrCB(_MenuName _Lib _Cell _View _a _b)
	stop())

list(nil
	'start start
	'openFile openFile
	'StartLmgrCB StartLmgrCB
	'StopLmgrCB StopLmgrCB
))

putprop(VrtImport['Softworks] VsCode 'VsCode)

)

; Library Manager Menu Callbacks
SdmVsCodeStartLmgrCB = VrtImport['Softworks]->VsCode->StartLmgrCB

printf("done\n")
