/*****************************************************************
 *                                                               *
 *    Softworks Software Data Manager PPTX Support Package     *
 *                                                               *
 *****************************************************************/
printf("  Loading PPTX support...")

SdmPPTX = let((
	(viewSetup '(
	;(viewType  appName dataTrigger parentType)
	("pptx" "libreoffice_pptx" "SdmPPTXDataTrigger" nil)
	)))

; Register All PPTX Custom Cellviews
procedure(init() let(((out t))
	Sdm->initDeRegApp(viewSetup)
))

; uninitialize all PPTX views so they can be redefined
procedure(uninit() let(((out t))
	Sdm->uninitDeRegApp(viewSetup)
))

; Open a PPTX view with the function specified by startReader
;  startReader should start the editor with no arguments specified.
;  startReader should open any number of views when specified as additional arguments.
procedure(DataTrigger(@optional argList)
	let((libName cellName file fileName extension objId viewFileName viewName rootType templateName)
	libName = argList->libName
	cellName = argList->cellName
    viewName = argList->viewName
	rootType = argList->rootType
	viewFileName = argList->viewFileId->name

    if( objId = ddGetObj(libName cellName viewName viewFileName nil "r") then
		; Open existing file
    	file = ddGetObjWritePath(objId)
		; Start editor
		if(isFile(file) then
			startReader(file)
		else
			warn("Warning, couldn't open %s / %s / %s as a PPTX view", libName cellName viewName))
	else
		SdmCombinedGUI(libName cellName viewName )
		/*
		 ;Create a new file by copying a template
		extension = case(rootType
			("pptx"     ".pptx")
			(t 			".pptx") ; default
		)
		templateName = strcat(rootType "Template" extension)
		fileName = strcat(cellName extension)

		if(objId = ddGetObj(libName cellName viewName fileName nil "w") then
			file = ddGetObjWritePath(objId)
			system(sprintf(nil "cp $SOFTWORKS_ROOT/src/pptx/%s %s" templateName file))
			startReader(file)
		else
			warn("Could not create the cellview file %s / %s / %s / %s" libName cellName viewName fileName))
*/

	)
	t
))

procedure(startReader(filePath)
	system(strcat( "libreoffice --impress " filePath))
)

list(nil
	'init init
	'uninit uninit
	'DataTrigger DataTrigger
))

;Global functions
SdmPPTXDataTrigger = SdmPPTX->DataTrigger

printf("done\n")
