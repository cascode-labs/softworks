 /*****************************************************************
  *                                                               *
  *              Softworks PDF view support                        *
  *                                                               *
  *   Adds a "pdf" view type to Cadence Virtuoso                  *
  *                                                               *
  *****************************************************************/
printf("  Loading PDF support...")

SdmPDF = let((
	(viewSetup '(
	;(viewType  appName dataTrigger parentType)
	("pdf_view" "firefox_pdf" "SdmPdfDataTrigger" nil)
	)))

; Register All PDF Custom Cellviews
procedure(init() let(((out t))
	Softworks->initDeRegApp(viewSetup)
))

; Unregister Cellviews
procedure(uninit() let(((out t))
	Softworks->uninitDeRegApp(viewSetup)
))

; Open a pdf view with the function specified by startReader
;  startReader should start the editor with no arguments specified.
;  startReader should open any number of views when specified as additional arguments.
procedure(DataTrigger(@optional argList )
	let(( libName cellName file fileName extension objId viewFileName viewName viewType appName)
	; printf("Calling SkyVer Power Point View Data Trigger on %L !\n", argList);
	libName = argList->libName
	cellName = argList->cellName
    viewName = argList->viewName
	rootType = argList->rootType
	appName = argList->appName
	viewFileName = argList->viewFileId->name

	if( objId = ddGetObj(libName cellName viewName viewFileName nil "r") then
        ; Open existing file
    	file = ddGetObjWritePath(objId)
		; Start editor
		if(isFile(file) then
			startReader(appName file)
		else
			warn("Warning, couldn't open %s / %s / %s as a PDF view", libName cellName viewName))
	else
		; Create a new file by copying a template
		SdmCombinedGUI(libName cellName viewName )
		/*extension = case(rootType
			("pdf"   ".pdf")
			(t 		 ".pdf") ; default
		)
		templateName = strcat(rootType "Template" extension)
		fileName = strcat(cellName extension)

		if(objId = ddGetObj(libName cellName viewName fileName nil "w") then
			file = ddGetObjWritePath(objId)
			system(sprintf(nil "cp $SOFTWORKS_ROOT/src/pdf/%s %s" templateName file))
			startReader(appName file)
		else
			warn("Could not create the cellview file %s / %s / %s / %s" libName cellName viewName fileName))*/
	)
	t
))

procedure(startReader(app filePath)
	system(strcat( "firefox " filePath))
)

list(nil
	'init init
	'uninit uninit
	'DataTrigger DataTrigger
))

;Global functions
SdmPdfDataTrigger = SdmPDF->DataTrigger

printf("done\n")
