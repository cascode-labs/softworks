/*****************************************************************
 *                                                               *
 *    Softworks Software Data Manager XLSX Support Module     *
 *                                                               *
 *****************************************************************/
printf("  Loading XLSX support...")

SdmXLSX = let((
	(viewSetup '(
	;(viewType  appName dataTrigger parentType)
	("xlsx" "libreoffice_xlsx" "SdmXLSXDataTrigger" nil)
	)))

; Register All XLSX Custom Cellviews
procedure(init() let(((out t))
	Softworks->initDeRegApp(viewSetup)
))

; uninitialize all XLSX views so they can be redefined
procedure(uninit() let(((out t))
	Softworks->uninitDeRegApp(viewSetup)
))

; Open a XLSX view with the function specified by startReader
;  startReader should start the editor with no arguments specified.
;  startReader should open any number of views when specified as additional arguments.
procedure(DataTrigger(@optional argList)
	let((libName cellName file fileName extension objId viewFileName viewName viewType appName)
	libName = argList->libName
	cellName = argList->cellName
    viewName = argList->viewName
	rootType = argList->rootType
	appName = argList->appName
	viewFileName = argList->viewFileId->name

    if( objId = ddGetObj(libName cellName viewName viewFileName nil "r") then
		; Open existing file
    	file = ddGetObjWritePath(objId)
		; Start editor
		if(isFile(file) then
			startReader(appName file)
		else
			warn("Warning, couldn't open %s / %s / %s as a XLSX view", libName cellName viewName))
	else
		SdmCombinedGUI(libName cellName viewName )
		; Create a new file by copying a template
		/*extension = case(rootType
			("xlsx"     ".xlsx")
			(t 			".xlsx") ; default
		)
		templateName = strcat(rootType "Template" extension)
		fileName = strcat(cellName extension)

		if(objId = ddGetObj(libName cellName viewName fileName nil "w") then
			file = ddGetObjWritePath(objId)
			system(sprintf(nil "cp $SOFTWORKS_ROOT/src/xlsx/%s %s" templateName file))
			startReader(appName file)
		else
			warn("Could not create the cellview file %s / %s / %s / %s" libName cellName viewName fileName))*/
	)
	t
))

procedure(startReader(app filePath)
	system(strcat( "libreoffice --calc " filePath))
)

list(nil
	'init init
	'uninit uninit
	'DataTrigger DataTrigger
))

;Global functions
SdmXLSXDataTrigger = SdmXLSX->DataTrigger

printf("done\n")
