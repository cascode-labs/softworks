printf("  Loading HTML support...")

let((HTML
	   (module_description "Adds an HTML (*.html) view type to Virtuoso")
	   (Softworks VrtImport['Softworks]))

HTML = let((
	(viewSetup '(
	;(viewType  appName dataTrigger parentType)
	("html" "firefox" "SdmHTMLDataTrigger" nil)
	)))

procedure(init()
	"Register HTML Cellview Types "
	let(((out t))
	Softworks->initDeRegApp(viewSetup)
))

; uninitialize all Python views so they can be redefined
procedure(uninit() let(((out t))
	Softworks->uninitDeRegApp(viewSetup)
))

; Open an HTML view with the function specified by startReader
;  startReader should start the editor with no arguments specified.
;  startReader should open any number of views when specified as additional arguments.
procedure(DataTrigger(@optional argList)
	let((libName cellName file fileName extension objId viewFileName viewName viewType appName)
	libName = argList->libName
	cellName = argList->cellName
    viewName = argList->viewName
	rootType = argList->rootType
	appName = argList->appName
	viewFileName = argList->viewFileId->name

    if( objId = ddGetObj(libName cellName viewName viewFileName nil "r") then
		; Open existing file
    	file = ddGetObjWritePath(objId)
		; Start editor
		if(isFile(file) then
			startReader(appName file)
		else
			warn("Warning, couldn't open %s / %s / %s as a HTML view", libName cellName viewName))
	else
		SdmCombinedGUI(libName cellName viewName )
	)
	t
))

procedure(startReader(app filePath)
	system(strcat( "firefox " filePath))
)

list(nil
	'init init
	'uninit uninit
	'DataTrigger DataTrigger
))

putprop(Softworks HTML 'HTML)
HTML->init()

)

;Global functions
SdmHTMLDataTrigger = VrtImport['Softworks]->HTML->DataTrigger

printf("done\n")
